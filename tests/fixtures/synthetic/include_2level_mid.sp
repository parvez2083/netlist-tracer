.include 'include_2level_leaf.sp'
.subckt MID a b out
X1 a b out LEAF
.ends MID

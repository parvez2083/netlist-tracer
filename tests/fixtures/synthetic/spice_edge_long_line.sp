* Synthetic SPICE fixture: long netlist line
.SUBCKT test_long_line A B C D E F G H I J K L M N O P Q R S T U V W X Y Z
X1 A B C D E F G H I J K L M N O P Q R S T U V W X Y Z long_cell_name
.ENDS test_long_line

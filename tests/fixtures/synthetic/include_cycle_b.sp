.subckt CYCB b c
.include 'include_cycle_c.sp'
X1 b c CYCC
.ends CYCB

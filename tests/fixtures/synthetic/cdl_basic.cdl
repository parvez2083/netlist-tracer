* CDL netlist (SPICE-family with CDL markers)
* *.PININFO is a CDL-specific marker for pin definitions
*.PININFO nand3 (Y, A, B, C, VDD, VSS)

.SUBCKT nand3 Y A B C VDD VSS
M1 Y A VDD VDD pmos W=2u L=1u
M2 Y B VDD VDD pmos W=2u L=1u
M3 Y A 1 VSS nmos W=1u L=1u
M4 1 B VSS VSS nmos W=1u L=1u
.ENDS nand3

.SUBCKT top_cdl VDD VSS A B C Y
X1 Y A B C VDD VSS nand3
.ENDS top_cdl

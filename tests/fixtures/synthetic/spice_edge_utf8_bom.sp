* Synthetic SPICE fixture: UTF-8 BOM handling
.SUBCKT test_bom VDD VSS
X1 VDD VSS bom_cell
.ENDS test_bom

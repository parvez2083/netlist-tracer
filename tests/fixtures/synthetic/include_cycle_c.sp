.subckt CYCC c a
.include 'include_cycle_a.sp'
X1 c a CYCA
.ends CYCC

.SUBCKT TB inp out
X1 inp out INV
.ENDS TB

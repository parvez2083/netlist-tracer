* Synthetic SPICE fixture: CRLF line endings
.SUBCKT test_crlf A B
X1 A B test_cell
.ENDS test_crlf

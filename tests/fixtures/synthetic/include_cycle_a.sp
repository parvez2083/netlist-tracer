.subckt CYCA a b
.include 'include_cycle_b.sp'
X1 a b CYCB
.ends CYCA

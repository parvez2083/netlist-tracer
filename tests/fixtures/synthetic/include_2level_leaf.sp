.subckt LEAF a b out
R1 a b res=1k
R2 b out res=2k
.ends LEAF
